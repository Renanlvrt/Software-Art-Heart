# Ansys Electronics Desktop project, version 2024.1
materials:
  vacuum: permittivity=1
  copper: permeability=0.999991 conductivity=58000000
  air: permittivity=1.0006 permeability=1.0000004

design Maxwell3DDesign1 (Maxwell 3D, EddyCurrent, model units mm)
geometry:
  SecondaryCoil [copper] = user_primitive(SegmentedHelix/PolygonHelix.dll, PolygonSegments=0, PolygonRadius=1mm, StartHelixRadius=3mm, RadiusChange=2.5mm, Pitch=0mm, Turns=12, SegmentsPerTurn=36, RightHanded=1)
  SecondaryCoil.move(0mm, 0mm, 12mm)
  PolygonHelix7_ObjectFromFace1 = object_from(?.face(#13))
  Polyline6 = polyline((32.874773mm, 0.0030679667mm, 12.000013mm) (32.874773mm, (0.003067966682623+1.1) mm, 12.000013mm) (32.874773mm, (0.003067966682623+1.1) mm, (2.5+12.000012555475) mm) (20mm, (0.003067966682623+1.1) mm, (2.5+12.000012555475) mm) (20mm, (0.003067966682623-1.1) mm, (2.5+12.000012555475) mm) (2.9885337mm, (0.003067966682623-1.1) mm, (2.5+12.000012555475) mm) (2.9885337mm, (0.003067966682623-1) mm, 11.999987mm) (2.9885337mm, (0.003067966682623+0.15) mm, 11.999987mm))
  PolygonHelix7_ObjectFromFace1.sweep_along_path(Polyline6)
  SecondaryCoil.unite(PolygonHelix7_ObjectFromFace1)
  PrimaryCoil [copper] = user_primitive(SegmentedHelix/PolygonHelix.dll, PolygonSegments=0, PolygonRadius=1mm, StartHelixRadius=3mm, RadiusChange=2.5mm, Pitch=0mm, Turns=12, SegmentsPerTurn=36, RightHanded=1)
  PrimaryCoil.move(0mm, 0mm, 12mm)
  PolygonHelix7_ObjectFromFace2 = object_from(?.face(#949))
  Polyline7 = polyline((32.874773mm, 0.0030679667mm, 12.000013mm) (32.874773mm, (0.003067966682623+1.1) mm, 12.000013mm) (32.874773mm, (0.003067966682623+1.1) mm, (2.5+12.000012555475) mm) (20mm, (0.003067966682623+1.1) mm, (2.5+12.000012555475) mm) (20mm, (0.003067966682623-1.1) mm, (2.5+12.000012555475) mm) (2.9885337mm, (0.003067966682623-1.1) mm, (2.5+12.000012555475) mm) (2.9885337mm, (0.003067966682623-1) mm, 11.999987mm) (2.9885337mm, (0.003067966682623+0.15) mm, 11.999987mm))
  PolygonHelix7_ObjectFromFace2.sweep_along_path(Polyline7)
  PrimaryCoil.unite(PolygonHelix7_ObjectFromFace2)
  PrimaryCoil.move(0mm, 0mm, -12mm)
  PrimaryCoil.rotate(axis=X, angle=180deg)
  PrimaryCoil.mirror(point=(0mm, 0mm, 0mm), normal=(0mm, 1mm, 0mm))
  Rectangle1 = rectangle(corner=(25mm, (0.003067966682623-0.5) mm, (1.25+12.000012555475) mm), y_size=3mm, z_size=3mm)
  Rectangle2 = rectangle(corner=(25mm, (0.003067966682623-0.5) mm, -4.4mm), y_size=3mm, z_size=3mm)
  PrimaryCoil1 [copper] = user_primitive(SegmentedHelix/PolygonHelix.dll, PolygonSegments=0, PolygonRadius=1mm, StartHelixRadius=3mm, RadiusChange=2.5mm, Pitch=0mm, Turns=12, SegmentsPerTurn=36, RightHanded=1)
  PrimaryCoil1.move(0mm, 0mm, 12mm)
  PolygonHelix7_ObjectFromFace3 = object_from(?.face(#2872))
  Polyline8 = polyline((32.874773mm, 0.0030679667mm, 12.000013mm) (32.874773mm, (0.003067966682623+1.1) mm, 12.000013mm) (32.874773mm, (0.003067966682623+1.1) mm, (2.5+12.000012555475) mm) (20mm, (0.003067966682623+1.1) mm, (2.5+12.000012555475) mm) (20mm, (0.003067966682623-1.1) mm, (2.5+12.000012555475) mm) (2.9885337mm, (0.003067966682623-1.1) mm, (2.5+12.000012555475) mm) (2.9885337mm, (0.003067966682623-1) mm, 11.999987mm) (2.9885337mm, (0.003067966682623+0.15) mm, 11.999987mm))
  PolygonHelix7_ObjectFromFace3.sweep_along_path(Polyline8)
  PrimaryCoil1.unite(PolygonHelix7_ObjectFromFace3)
  PrimaryCoil1.move(0mm, 0mm, -12mm)
  PrimaryCoil1.rotate(axis=X, angle=180deg)
  PrimaryCoil1.mirror(point=(0mm, 0mm, 0mm), normal=(0mm, 1mm, 0mm))
  SecondaryCoil1 [copper] = user_primitive(SegmentedHelix/PolygonHelix.dll, PolygonSegments=0, PolygonRadius=1mm, StartHelixRadius=3mm, RadiusChange=2.5mm, Pitch=0mm, Turns=12, SegmentsPerTurn=36, RightHanded=1)
  SecondaryCoil1.move(0mm, 0mm, 12mm)
  PolygonHelix7_ObjectFromFace4 = object_from(?.face(#3810))
  Polyline9 = polyline((32.874773mm, 0.0030679667mm, 12.000013mm) (32.874773mm, (0.003067966682623+1.1) mm, 12.000013mm) (32.874773mm, (0.003067966682623+1.1) mm, (2.5+12.000012555475) mm) (20mm, (0.003067966682623+1.1) mm, (2.5+12.000012555475) mm) (20mm, (0.003067966682623-1.1) mm, (2.5+12.000012555475) mm) (2.9885337mm, (0.003067966682623-1.1) mm, (2.5+12.000012555475) mm) (2.9885337mm, (0.003067966682623-1) mm, 11.999987mm) (2.9885337mm, (0.003067966682623+0.15) mm, 11.999987mm))
  PolygonHelix7_ObjectFromFace4.sweep_along_path(Polyline9)
  SecondaryCoil1.unite(PolygonHelix7_ObjectFromFace4)
  PrimaryCoil1.intersect(Rectangle2)
  SecondaryCoil1.intersect(Rectangle1)
  Region [air] = region(absolute_offset=50mm on all sides)
boundaries and excitations:
  PrimaryCurrent: Current Objects=PrimaryCoil1 Phase=0deg Current=182mA IsSolid=true Point_out_of_terminal=false
  SecondaryCurrent: Current Objects=SecondaryCoil1 Phase=-90deg Current=182mA IsSolid=true Point_out_of_terminal=false
parameters:
  Matrix1: Matrix PrimaryCurrent, SecondaryCurrent:
mesh:
  initial mesh: GlobalCurvilinear{Apply}
setups:
  Setup1: EddyCurrent MaximumPasses=10 MinimumPasses=2 MinimumConvergedPasses=1 PercentRefinement=30 PercentError=1 RelativeResidual=1e-05 NonLinearResidual=0.0001 Frequency=50kHz SweepRanges{100kHz to 1.5MHz step 200kHz} SaveAllFields LossAdaptiveCtrl=0.5
reports:
  Coupling Coeff Table 1: Matrix1.CplCoef(PrimaryCurrent,SecondaryCurrent) vs Freq on Setup1 : LastAdaptive
  L Table 1: Matrix1.L(PrimaryCurrent,PrimaryCurrent), Matrix1.L(PrimaryCurrent,SecondaryCurrent), Matrix1.L(SecondaryCurrent,SecondaryCurrent) vs Freq on Setup1 : LastAdaptive
  R Table 1: Matrix1.R(PrimaryCurrent,PrimaryCurrent), Matrix1.R(PrimaryCurrent,SecondaryCurrent), Matrix1.R(SecondaryCurrent,SecondaryCurrent) vs Freq on Setup1 : LastAdaptive
  Loss Table 1: CoreLoss vs Freq on Setup1 : LastAdaptive
  Loss Table 2: SolidLoss vs Freq on Setup1 : LastAdaptive
  Loss Table 3: StrandedLoss vs Freq on Setup1 : LastAdaptive
  Loss Table 4: StrandedLossAC vs Freq on Setup1 : LastAdaptive
  Loss Table 5: StrandedLossR vs Freq on Setup1 : LastAdaptive
